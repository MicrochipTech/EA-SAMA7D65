|   Microchip Technology Inc.
|   SAMUA7D65 System-In-Package Series -  DDR3L SDRAM
|   "Up to to 1-GHz Arm Cortex-A7, MIPI/LVDS Display,
|   Dual Gigabit Ethernet, Audio and Security
| Part Number   Package
| SAMA7D65D1G-V/XHB   TFBGA422   422-ball TFBGA 16x16mm Body, 0.5mm pitch
| SAMA7D65D2G-V/XHB   TFBGA422   422-ball TFBGA 16x16mm Body, 0.5mm pitch
| SAMA7D65D4G-V/XHB   TFBGA422   422-ball TFBGA 16x16mm Body, 0.5mm pitch
[IBIS ver]   5.0
[File name]   sama7d65dxg_xhb.ibs
[File Rev]   1.0
[Date]   January 26 2026
[Source]   From silicon level SPICE model simulation at Microchip.
[Notes]   This IBIS model is for the Microchip SAMA7D65DxG (1G/2/G/4G)
   SiP device in 422-ball TFBGA 16x16mm Body, 0.5mm pitch.
   Revision History:
   Rev 1.0: 26/01/2026  Author: PFi
   - HSPICE/IBIS Correlation comparison with HyperLynx
   IBIS simulation.
   - IBIS Quality Level (IQ) analysis based on Specification 2.0
   - Visual inspection where needed.
   - IQ SUMMARY Overall Quality for component and models
   - IBISCHK7 V7.2.1
   IQ Quality Level for Component:
   -  IQ2.
   IQ Quality Level for Model HSIO_* / GPIO_* IOs:
   - IQ2(S).
   - SPICE to IBIS correlation for Clamp, IV and VT tables
   FOM > 98%
   IQ Quality Level for Model for (LP)DDRxx(L) IOs:
   - IQ2.
[Disclaimer]   (C) Copyright Microchip Corporation 2026
|   Component SAMA7D65D1G, SAMA7D65D2G, SAMA7D65D4G
[Component]   SAMA7D65DxG
[Manufacturer]  Microchip Technology Inc.
[Package]
| variable   typ   min   max
R_pkg   216m   58m   454m
L_pkg   2.7nH   0.7nH   5.6nH
C_pkg   0.9pF   0.4pF   1.7pF
[Pin]   signal_name   model_name   R_pin   L_pin   C_pin
AF25   PA0   HSIO   157m   2.0nH   0.8pF
AF24   PA1   HSIO   198m   2.7nH   0.8pF
AG25   PA2   HSIO   197m   2.4nH   0.9pF
AK30   PA3   HSIO   259m   3.5nH   0.9pF
AK29   PA4   HSIO   224m   3.0nH   0.9pF
AK31   PA5   HSIO   283m   3.8nH   1.0pF
AK28   PA6   HSIO   210m   2.8nH   0.9pF
AL30   PA7   HSIO   289m   3.8nH   1.0pF
AG23   PA8   HSIO   207m   2.7nH   0.9pF
AL28   PA9   HSIO   260m   3.4nH   1.0pF
AF22   PA10   HSIO   171m   2.1nH   0.8pF
AG24   PA11   HSIO   208m   2.5nH   0.9pF
AL29   PA12   HSIO   305m   3.9nH   1.0pF
AF23   PA13   HSIO   169m   2.2nH   0.8pF
AL26   PA14   GPIO   269m   3.5nH   0.9pF
AG22   PA15   GPIO   181m   2.3nH   0.8pF
AK26   PA16   GPIO   248m   3.3nH   0.9pF
AG21   PA17   GPIO   226m   2.8nH   1.0pF
AL25   PA18   GPIO   259m   3.4nH   0.9pF
AK25   PA19   GPIO   252m   3.3nH   1.0pF
AG20   PA20   GPIO   243m   2.9nH   1.1pF
AL24   PA21   GPIO   264m   3.4nH   1.0pF
AF21   PA22   GPIO   131m   1.7nH   0.6pF
AK24   PA23   GPIO   242m   3.1nH   0.9pF
AF20   PA24   GPIO   137m   1.8nH   0.7pF
V30   PA25   GPIO   169m   2.3nH   0.7pF
T25   PA26   GPIO   90m   1.0nH   0.6pF
R30   PA27   GPIO   140m   1.9nH   0.5pF
W26   PA28   GPIO   131m   1.6nH   0.7pF
U30   PA29   GPIO   154m   2.0nH   0.7pF
U25   PA30   GPIO   156m   1.9nH   0.7pF
R31   PA31   GPIO   155m   2.1nH   0.5pF
R25   PB0   GPIO   89m   1.0nH   0.6pF
U31   PB1   GPIO   208m   2.8nH   0.7pF
V25   PB2   GPIO   194m   2.4nH   0.9pF
V31   PB3   GPIO   228m   3.2nH   0.7pF
U26   PB4   GPIO   109m   1.3nH   0.7pF
P30   PB5   GPIO   135m   1.8nH   0.5pF
V26   PB6   GPIO   185m   2.3nH   0.8pF
P31   PB7   GPIO   149m   2.0nH   0.5pF
AB31   PB8   HSIO   197m   2.6nH   0.7pF
AA30   PB9   HSIO   134m   1.7nH   0.6pF
AA28   PB10   HSIO   101m   1.1nH   0.6pF
AB28   PB11   HSIO   189m   2.1nH   0.9pF
AA25   PB12   HSIO   137m   1.5nH   0.7pF
Y31   PB13   HSIO_PB13_PB14  165m   2.1nH   0.7pF
AA31   PB14   HSIO_PB13_PB14  184m   2.6nH   0.6pF
AA26   PB15   HSIO   134m   1.6nH   0.8pF
W31   PB16   HSIO   175m   2.4nH   0.6pF
Y25   PB17   HSIO   176m   2.0nH   0.9pF
W30   PB18   HSIO   173m   2.4nH   0.6pF
Y30   PB19   HSIO   157m   1.9nH   0.8pF
W25   PB20   HSIO   154m   1.8nH   0.8pF
B22   PB21   HSIO   232m   3.0nH   1.0pF
A22   PB22   HSIO   274m   3.6nH   1.0pF
B21   PB23   HSIO   244m   3.0nH   1.0pF
A21   PB24   HSIO   270m   3.3nH   1.0pF
E24   PB25   HSIO   128m   1.7nH   0.7pF
A20   PB26   HSIO   282m   3.7nH   1.0pF
E23   PB27   HSIO   146m   1.8nH   0.7pF
A7   PB28   GPIO   376m   4.6nH   1.3pF
B6   PB29   GPIO   341m   4.0nH   1.6pF
B7   PB30   GPIO   364m   4.6nH   1.3pF
E19   PB31   GPIO   176m   2.4nH   0.6pF
R20   PC0   GPIO   124m   1.4nH   0.7pF
F19   PC1   GPIO   149m   1.9nH   0.6pF
N20   PC2   GPIO   86m   1.0nH   0.6pF
B4   PC3   GPIO   383m   4.4nH   1.7pF
E11   PC4   GPIO   256m   3.5nH   0.9pF
E10   PC5   GPIO   248m   2.7nH   1.2pF
F8   PC6   GPIO   289m   3.3nH   1.3pF
A6   PC7   GPIO   397m   5.0nH   1.3pF
M20   PC8   GPIO   71m   0.8nH   0.5pF
B11   PC9   GPIO   309m   3.9nH   1.1pF
E9   PC10   GPIO   305m   3.5nH   1.3pF
A4   PC11   GPIO   410m   5.3nH   1.5pF
F11   PC12   GPIO   229m   3.0nH   0.9pF
A3   PC13   GPIO   431m   5.4nH   1.5pF
F9   PC14   GPIO   252m   3.0nH   1.2pF
E8   PC15   GPIO   307m   4.0nH   1.1pF
F10   PC16   GPIO   256m   3.2nH   1.0pF
A12   PC17   GPIO   293m   3.5nH   1.1pF
L18   PC18   GPIO   66m   0.8nH   0.5pF
A11   PC19   GPIO   319m   4.2nH   1.1pF
K18   PC20   GPIO   97m   1.1nH   0.5pF
K19   PC21   GPIO   64m   0.8nH   0.4pF
E7   PC22   GPIO   335m   4.1nH   1.2pF
E12   PC23   GPIO   228m   2.8nH   0.9pF
E13   PC24   GPIO   205m   2.6nH   0.8pF
A10   PC25   GPIO   326m   4.0nH   1.1pF
F13   PC26   GPIO   181m   2.3nH   0.8pF
B24   PC27   HSIO   246m   3.1nH   0.9pF
F24   PC28   HSIO   163m   2.0nH   0.8pF
B25   PC29   HSIO   252m   3.4nH   0.9pF
E25   PC30   HSIO   166m   2.2nH   0.7pF
A24   PC31   HSIO   281m   3.7nH   1.0pF
A25   PD0   HSIO   275m   3.5nH   1.0pF
B26   PD1   GPIO   257m   3.3nH   0.9pF
E26   PD2   GPIO   162m   2.0nH   0.8pF
A26   PD3   GPIO   275m   3.5nH   1.0pF
B27   PD4   GPIO   234m   3.0nH   1.0pF
A27   PD5   GPIO   276m   3.5nH   1.0pF
B28   PD6   GPIO   244m   3.1nH   1.0pF
A28   PD7   GPIO   267m   3.3nH   1.0pF
F30   PD8   GPIO   153m   2.0nH   0.7pF
E30   PD9   GPIO   183m   2.4nH   0.7pF
F31   PD10   GPIO   154m   2.0nH   0.7pF
E31   PD11   GPIO   194m   2.6nH   0.8pF
D31   PD12   GPIO   239m   3.3nH   0.8pF
D30   PD13   GPIO   240m   3.1nH   0.9pF
G31   PD14   GPIO   192m   2.7nH   0.7pF
B30   PD15   GPIO   283m   3.6nH   1.1pF
C31   PD16   GPIO   280m   3.7nH   0.9pF
A29   PD17   GPIO   324m   4.1nH   1.2pF
L28   PD18   GPIO   102m   1.3nH   0.5pF
H31   PD19   GPIO   181m   2.5nH   0.6pF
G30   PD20   GPIO   169m   2.0nH   0.8pF
N30   PD21   GPIO   116m   1.4nH   0.5pF
K30   PD22   GPIO   148m   2.0nH   0.6pF
M25   PD23   GPIO   81m   0.9nH   0.6pF
K31   PD24   GPIO   169m   2.3nH   0.6pF
N26   PD25   GPIO   63m   0.8nH   0.5pF
L30   PD26   GPIO   140m   1.9nH   0.5pF
M28   PD27   GPIO   67m   0.8nH   0.4pF
N28   PD28   GPIO   96m   1.1nH   0.5pF
R26   PD29   GPIO   102m   1.2nH   0.6pF
L31   PD30   GPIO   164m   2.2nH   0.6pF
M31   PD31   GPIO   162m   2.2nH   0.5pF
P26   PE0   GPIO   63m   0.8nH   0.5pF
M30   PE1   GPIO   158m   2.1nH   0.6pF
P28   PE2   GPIO   60m   0.7nH   0.4pF
N31   PE3   GPIO   160m   2.2nH   0.5pF
AK18   PE4   GPIO   260m   3.3nH   0.9pF
AL18   PE5   GPIO   267m   3.4nH   1.0pF
AK19   PE6   GPIO   252m   3.2nH   0.9pF
AL19   PE7   GPIO   262m   3.3nH   0.9pF
AK20   PE8   GPIO   248m   3.2nH   0.9pF
AL20   PE9   GPIO   260m   3.3nH   0.9pF
AK22   PE10   GPIO   245m   3.1nH   0.9pF
AL22   PE11   GPIO   253m   3.2nH   0.9pF
AK21   PE12   GPIO   244m   3.1nH   0.9pF
AL21   PE13   GPIO   252m   3.2nH   0.9pF
L19   AUDIOCLK   GPIO   58m   0.7nH   0.5pF
E2   HHSDMA   USB_DM   445m   5.5nH   1.5pF
G2   HHSDMB   USB_DM   437m   5.3nH   1.5pF
J2   HHSDMC   USB_DM   420m   5.1nH   1.4pF
E1   HHSDPA   USB_DP   454m   5.6nH   1.6pF
G1   HHSDPB   USB_DP   442m   5.4nH   1.5pF
J1   HHSDPC   USB_DP   430m   5.2nH   1.5pF
M18   VBAT   POWER
R28   VDDGMAC0   POWER
J30   VDDGMAC1   POWER
P20   VDDIN33   POWER
Y22   VDDIOP0   POWER
H30   VDDIOP1   POWER
AA21   VDDLVDS   POWER
L17   VDDOUT25   POWER
AF19   VDDIN25   POWER
U28   VDDQSPI0   POWER
AC30   VDDSDMMC0   POWER
M22   VDDSDMMC1   POWER
F25   VDDSDMMC2   POWER
N15   VDDUTMI   POWER
A1   GND   GND
A2   GND   GND
A8   GND   GND
A13   GND   GND
A16   GND   GND
A19   GND   GND
A23   GND   GND
A31   GND   GND
B2   GND   GND
B3   GND   GND
B8   GND   GND
B12   GND   GND
B13   GND   GND
B19   GND   GND
D1   GND   GND
D2   GND   GND
E6   GND   GND
F1   GND   GND
F2   GND   GND
F6   GND   GND
F7   GND   GND
F12   GND   GND
F20   GND   GND
F23   GND   GND
H1   GND   GND
H2   GND   GND
J31   GND   GND
K1   GND   GND
K2   GND   GND
K4   GND   GND
K12   GND   GND
K13   GND   GND
K20   GND   GND
L1   GND   GND
L7   GND   GND
L11   GND   GND
L13   GND   GND
L14   GND   GND
M2   GND   GND
M7   GND   GND
M9   GND   GND
M10   GND   GND
M12   GND   GND
M14   GND   GND
N1   GND   GND
N13   GND   GND
N25   GND   GND
P2   GND   GND
P7   GND   GND
P9   GND   GND
P10   GND   GND
P12   GND   GND
P14   GND   GND
P25   GND   GND
R1   GND   GND
R4   GND   GND
R6   GND   GND
R7   GND   GND
R9   GND   GND
R10   GND   GND
R12   GND   GND
T2   GND   GND
T7   GND   GND
T13   GND   GND
T20   GND   GND
T31   GND   GND
U1   GND   GND
U13   GND   GND
U17   GND   GND
U19   GND   GND
U7   GND   GND
U9   GND   GND
V2   GND   GND
V4   GND   GND
V6   GND   GND
V10   GND   GND
V12   GND   GND
V13   GND   GND
V20   GND   GND
V22   GND   GND
V23   GND   GND
W1   GND   GND
W7   GND   GND
W9   GND   GND
W13   GND   GND
W17   GND   GND
W20   GND   GND
W22   GND   GND
W23   GND   GND
Y2   GND   GND
Y4   GND   GND
Y7   GND   GND
Y10   GND   GND
Y14   GND   GND
Y20   GND   GND
AA1   GND   GND
AA7   GND   GND
AA13   GND   GND
AA14   GND   GND
AB2   GND   GND
AB4   GND   GND
AB12   GND   GND
AB18   GND   GND
AC1   GND   GND
AC31   GND   GND
AD2   GND   GND
AE1   GND   GND
AF2   GND   GND
AF6   GND   GND
AF8   GND   GND
AF9   GND   GND
AF10   GND   GND
AF11   GND   GND
AF13   GND   GND
AG1   GND   GND
AG7   GND   GND
AG9   GND   GND
AG12   GND   GND
AG19   GND   GND
AG26   GND   GND
AH2   GND   GND
AJ1   GND   GND
AK2   GND   GND
AK4   GND   GND
AK6   GND   GND
AK8   GND   GND
AK10   GND   GND
AK12   GND   GND
AK14   GND   GND
AL1   GND   GND
AL3   GND   GND
AL5   GND   GND
AL7   GND   GND
AL9   GND   GND
AL11   GND   GND
AL13   GND   GND
AL16   GND   GND
AL23   GND   GND
AL31   GND   GND
L4   VDD   POWER
L6   VDD   POWER
M1   VDD   POWER
N2   VDD   POWER
N4   VDD   POWER
N6   VDD   POWER
N7   VDD   POWER
N9   VDD   POWER
N10   VDD   POWER
N12   VDD   POWER
P1   VDD   POWER
P4   VDD   POWER
P6   VDD   POWER
P13   VDD   POWER
R2   VDD   POWER
R13   VDD   POWER
T1   VDD   POWER
T4   VDD   POWER
T6   VDD   POWER
T12   VDD   POWER
U2   VDD   POWER
U6   VDD   POWER
U10   VDD   POWER
U12   VDD   POWER
V1   VDD   POWER
V7   VDD   POWER
V9   VDD   POWER
V14   VDD   POWER
W2   VDD   POWER
W4   VDD   POWER
W6   VDD   POWER
W10   VDD   POWER
W12   VDD   POWER
Y1   VDD   POWER
Y9   VDD   POWER
Y12   VDD   POWER
AA2   VDD   POWER
AA4   VDD   POWER
AA6   VDD   POWER
AA11   VDD   POWER
AB1   VDD   POWER
AB13   VDD   POWER
AC2   VDD   POWER
AD1   VDD   POWER
AE2   VDD   POWER
AF1   VDD   POWER
AF7   VDD   POWER
AF12   VDD   POWER
AG2   VDD   POWER
AG6   VDD   POWER
AG8   VDD   POWER
AG10   VDD   POWER
AG11   VDD   POWER
AG13   VDD   POWER
AH1   VDD   POWER
AK5   VDD   POWER
AK7   VDD   POWER
AK11   VDD   POWER
AK13   VDD   POWER
AL4   VDD   POWER
AL6   VDD   POWER
AL8   VDD   POWER
AL10   VDD   POWER
AL12   VDD   POWER
AL14   VDD   POWER
B16   VDDCORE   POWER
K28   VDDCORE   POWER
L15   VDDCORE   POWER
L21   VDDCORE   POWER
R15   VDDCORE   POWER
T30   VDDCORE   POWER
U20   VDDCORE   POWER
U22   VDDCORE   POWER
U23   VDDCORE   POWER
W15   VDDCORE   POWER
Y23   VDDCORE   POWER
AB20   VDDCORE   POWER
AF26   VDDCORE   POWER
AK16   VDDCORE   POWER
N17   VDDANA   POWER
N19   VDDANA   POWER
F26   VDDCPU   POWER
M23   VDDCPU   POWER
N23   VDDCPU   POWER
P23   VDDCPU   POWER
R23   VDDCPU   POWER
P18   VDDIODDR   POWER
P19   VDDIODDR   POWER
R17   VDDIODDR   POWER
R19   VDDIODDR   POWER
T16   VDDIODDR   POWER
T18   VDDIODDR   POWER
T19   VDDIODDR   POWER
U15   VDDIODDR   POWER
V18   VDDIODDR   POWER
V19   VDDIODDR   POWER
W19   VDDIODDR   POWER
Y18   VDDIODDR   POWER
AA15   VDDIODDR   POWER
AA17   VDDIODDR   POWER
AA18   VDDIODDR   POWER
AA19   VDDIODDR   POWER
AB19   VDDIODDR   POWER
K14   ADVREFP   NC
B20   WKUP0   NC
B14   XIN   NC
A18   XIN32   NC
A14   XOUT   NC
B18   XOUT32   NC
L2   DDR_VREF   NC
AB14   DDR_VREF   NC
R22   JTAGSEL   NC
P22   TST   NC
A9   NRST_OUT   NC
V28   QSPI0_CAL   NC
AB30   SDMMC0_CAL   NC
L25   SDMMC1_CAL   NC
L26   SDMMC2_CAL   NC
E20   SHDN   NC
B1   HHSRTUNE   NC
E21   LPM   NC
Y28   MIPI_AVDD   NC
AF30   MIPI_CLKN   NC
AF31   MIPI_CLKP   NC
AH30   MIPI_DN0   NC
AG30   MIPI_DN1   NC
AE30   MIPI_DN2   NC
AD30   MIPI_DN3   NC
AH31   MIPI_DP0   NC
AG31   MIPI_DP1   NC
AE31   MIPI_DP2   NC
AD31   MIPI_DP3   NC
W28   MIPI_REXT   NC
B10   NRST   NC
F21   PIOBU0   NC
E22   PIOBU1   NC
N22   PIOBU2   NC
F22   PIOBU3   NC
M4   DDRM_ZQ   NC
T14   DDR_ZQ   NC
|**********************DIFF PIN************************************************
[Diff pin]  inv_pin   vdiff   tdelay_typ  tdelay_min  tdelay_max
|QSPIO_SCK   QSPI0_SPCKN
Y31   AA31   NA   NA   NA   NA
|USB DP   USB DM
E1   E2   0.2   0   NA   NA
G1   G2   0.2   0   NA   NA
J1   J2   0.2   0   NA   NA
|END COMPONENT SAMA7D65D4G ****************************************************
|   Model Selector
[Model Selector] HSIO_PB13_PB14
| 1.8V Voltage range
HSIO_PB13_IN_OUT_50_1v8   1v8 HSIO, Input/Output (Z0=50-Ohm)
HSIO_PB13_IN_OUT_66_1v8   1v8 HSIO, Input/Output (Z0=66-Ohm)
HSIO_PB13_IN_OUT_33_1v8   1v8 HSIO, Input/Output (Z0=33-Ohm)
HSIO_PB13_IN_OUT_100_1v8   1v8 HSIO, Input/Output (Z0=100-Ohm)
HSIO_PB14_IN_OUT_50_1v8   1v8 HSIO, Input/Output (Z0=50-Ohm)
HSIO_PB14_IN_OUT_66_1v8   1v8 HSIO, Input/Output (Z0=66-Ohm)
HSIO_PB14_IN_OUT_33_1v8   1v8 HSIO, Input/Output (Z0=33-Ohm)
HSIO_PB14_IN_OUT_100_1v8   1v8 HSIO, Input/Output (Z0=100-Ohm)
| 3.3V Voltage range
HSIO_PB13_IN_OUT_42_3v3   3v3 HSIO, Input/Output (Z0=42-Ohm)
HSIO_PB13_IN_OUT_56_3v3   3v3 HSIO, Input/Output (Z0=56-Ohm)
HSIO_PB13_IN_OUT_28_3v3   3v3 HSIO, Input/Output (Z0=28-Ohm)
HSIO_PB13_IN_OUT_84_3v3   3v3 HSIO, Input/Output (Z0=84-Ohm)
HSIO_PB14_IN_OUT_42_3v3   3v3 HSIO, Input/Output (Z0=42-Ohm)
HSIO_PB14_IN_OUT_56_3v3   3v3 HSIO, Input/Output (Z0=56-Ohm)
HSIO_PB14_IN_OUT_28_3v3   3v3 HSIO, Input/Output (Z0=28-Ohm)
HSIO_PB14_IN_OUT_84_3v3   3v3 HSIO, Input/Output (Z0=84-Ohm)
[Model Selector] HSIO
| 1.8V Voltage range
HSIO_IN_OUT_50_1v8   1v8  HSIO, Input or Output (Z0=50-Ohm)
HSIO_IN_OUT_66_1v8   1v8  HSIO, Input or Output (Z0=66-Ohm)
HSIO_IN_OUT_33_1v8   1v8  HSIO, Input or Output (Z0=33-Ohm)
HSIO_IN_OUT_100_1v8   1v8  HSIO, Input or Output (Z0=100-Ohm)
| 3.3V Voltage range
HSIO_IN_OUT_42_3v3   3v3 HSIO, Input or Output (Z0=42-Ohm)
HSIO_IN_OUT_56_3v3   3v3 HSIO, Input or Output (Z0=56-Ohm)
HSIO_IN_OUT_28_3v3   3v3 HSIO, Input or Output (Z0=28-Ohm)
HSIO_IN_OUT_84_3v3   3v3 HSIO, Input or Output (Z0=84-Ohm)
[Model Selector] GPIO
| 1.8V Voltage range
GPIO_DRV0_SR0_1v8   1v8 GPIO, Input or Output (Drive = 0 / Slew Rate = 0)
GPIO_DRV0_SR1_1v8   1v8 GPIO, Input or Output (Drive = 0 / Slew Rate = 1)
GPIO_DRV1_SR0_1v8   1v8 GPIO, Input or Output (Drive = 1 / Slew Rate = 0)
GPIO_DRV1_SR1_1v8   1v8 GPIO, Input or Output (Drive = 1 / Slew Rate = 1)
| 3.3V Voltage range
GPIO_DRV0_SR0_3v3   3v3 GPIO, Input or Output (Drive = 0 / Slew Rate = 0)
GPIO_DRV0_SR1_3v3   3v3 GPIO, Input or Output (Drive = 0 / Slew Rate = 1)
GPIO_DRV1_SR0_3v3   3v3 GPIO, Input or Output (Drive = 1 / Slew Rate = 0)
GPIO_DRV1_SR1_3v3   3v3 GPIO, Input or Output (Drive = 1 / Slew Rate = 1)
[Model Selector] USB_DP
DP_FS Full-Speed Mode
DP_HS High-Speed Mode
[Model Selector] USB_DM
DM_FS Full-Speed Mode
DM_HS High-Speed Mode
| Models and submodels in the file (36): HSIO_PB14_IN_OUT_50_1v8 (I/O), HSIO_PB14_IN_OUT_66_1v8 (I/O), HSIO_PB14_IN_OUT_33_1v8 (I/O), HSIO_PB14_IN_OUT_100_1v8 (I/O), HSIO_PB13_IN_OUT_50_1v8 (I/O), HSIO_PB13_IN_OUT_66_1v8 (I/O), HSIO_PB13_IN_OUT_33_1v8 (I/O), HSIO_PB13_IN_OUT_100_1v8 (I/O), HSIO_IN_OUT_50_1v8 (I/O), HSIO_IN_OUT_66_1v8 (I/O), HSIO_IN_OUT_33_1v8 (I/O), HSIO_IN_OUT_100_1v8 (I/O), GPIO_DRV0_SR0_1v8 (I/O), GPIO_DRV0_SR1_1v8 (I/O), GPIO_DRV1_SR0_1v8 (I/O), GPIO_DRV1_SR1_1v8 (I/O), HSIO_PB14_IN_OUT_42_3v3 (I/O), HSIO_PB14_IN_OUT_56_3v3 (I/O), HSIO_PB14_IN_OUT_28_3v3 (I/O), HSIO_PB14_IN_OUT_84_3v3 (I/O), HSIO_PB13_IN_OUT_42_3v3 (I/O), HSIO_PB13_IN_OUT_56_3v3 (I/O), HSIO_PB13_IN_OUT_28_3v3 (I/O), HSIO_PB13_IN_OUT_84_3v3 (I/O), HSIO_IN_OUT_42_3v3 (I/O), HSIO_IN_OUT_56_3v3 (I/O), HSIO_IN_OUT_28_3v3 (I/O), HSIO_IN_OUT_84_3v3 (I/O), GPIO_DRV0_SR0_3v3 (I/O), GPIO_DRV0_SR1_3v3 (I/O), GPIO_DRV1_SR0_3v3 (I/O), GPIO_DRV1_SR1_3v3 (I/O), DP_FS (I/O), DP_HS (I/O), DM_FS (I/O), DM_HS (I/O)
